// Keccak Accelerator IP - Loosely
// Register definition for reggen.py 
// Author: Federico Runco

{
  name: "keccak",
  clock_primary: "clk_i",
  reset_primary: "rst_ni",
  bus_interfaces: [
    {
      protocol: "reg_iface", 
      direction: "device" 
    }
  ],
  regwidth: "64",
  registers: [
    {
      multireg: {
        name: "DATA",
        desc: "I/O cryptographic state register of the Keccak AXI Accellerator",
        count: "25",
        cname: "data",
        swaccess: "rw",
        hwaccess: "hrw",
        fields: [
          { bits: "63:0" }
        ]
      }
    },
    {
      name: "CSREG",
      desc: "Control and status register for Keccak AXI Accellerator",
      swaccess: "rw",
      hwaccess: "hrw",
      fields: [
        {
          bits: "0",
          name: "START",
          desc: "Start the permutation"
        },
        {
          bits: "1",
          name: "DONE",
          desc: "Asserted if permutation is done"
        }
      ]
    },
    {
      name: "JOB_SRC_ADDR",
      desc: "Physical address of raw input bytes for the DMA-driven absorb job",
      swaccess: "rw",
      hwaccess: "hro",
      fields: [ { bits: "63:0" } ]
    },
    {
      name: "JOB_SRC_LEN",
      desc: "Number of bytes to DMA-absorb from JOB_SRC_ADDR",
      swaccess: "rw",
      hwaccess: "hro",
      fields: [ { bits: "31:0" } ]
    },
    {
      name: "JOB_DST_ADDR",
      desc: "Physical address to DMA-squeeze output bytes into",
      swaccess: "rw",
      hwaccess: "hro",
      fields: [ { bits: "63:0" } ]
    },
    {
      name: "JOB_DST_LEN",
      desc: "Number of bytes to DMA-squeeze into JOB_DST_ADDR",
      swaccess: "rw",
      hwaccess: "hro",
      fields: [ { bits: "31:0" } ]
    },
    {
      name: "JOBCTRL",
      desc: "DMA job descriptor control and status",
      swaccess: "rw",
      hwaccess: "hrw",
      fields: [
        {
          bits: "0",
          name: "GO",
          desc: "Start the DMA job"
        },
        {
          bits: "1",
          name: "FRESH",
          desc: "State starts from all-zero rather than XOR onto resident state"
        },
        {
          bits: "2",
          name: "FLIP",
          desc: "Apply SHAKE pad10*1 after the absorb portion of the job"
        },
        {
          bits: "3",
          name: "DONE",
          desc: "Asserted if the DMA job is done"
        },
        {
          bits: "11:4",
          name: "DPTR",
          desc: "Byte offset within the current rate block where this job's absorb begins (mirrors the caller's shake_context.dptr)"
        }
      ]
    },
    {
      name: "SAMP_T_ADDR",
      desc: "Physical base address of the HAWK sig_gauss() parity byte array t[] (t0 followed immediately by t1)",
      swaccess: "rw",
      hwaccess: "hro",
      fields: [ { bits: "63:0" } ]
    },
    {
      name: "SAMP_X_ADDR",
      desc: "Physical address of the first output sample byte for this job (caller's x + 4*j)",
      swaccess: "rw",
      hwaccess: "hro",
      fields: [ { bits: "63:0" } ]
    },
    {
      name: "SAMP_BITBASE",
      desc: "Constant added to the per-block sample index before indexing t[] (caller's 4*j)",
      swaccess: "rw",
      hwaccess: "hro",
      fields: [ { bits: "15:0" } ]
    },
    {
      name: "SAMP_NBLOCKS",
      desc: "Number of 16-sample/40-byte-squeeze blocks to generate for this job (n/8)",
      swaccess: "rw",
      hwaccess: "hro",
      fields: [ { bits: "15:0" } ]
    },
    {
      name: "SAMP_CTRL",
      desc: "HAWK sig_gauss() hardware CDT sampler job control and status. Requires the accelerator's DATA[] state to already be hardware-resident and shake_flip()-padded (not yet permuted) for the calling shake_context before GO is set.",
      swaccess: "rw",
      hwaccess: "hrw",
      fields: [
        {
          bits: "0",
          name: "GO",
          desc: "Start the sampler job"
        },
        {
          bits: "1",
          name: "DONE",
          desc: "Asserted if the sampler job is done"
        }
      ]
    },
    {
      name: "SAMP_SN",
      desc: "Accumulated squared norm (sum of r*r) over this job's samples, valid once SAMP_CTRL.DONE is set",
      swaccess: "ro",
      hwaccess: "hrw",
      fields: [ { bits: "31:0" } ]
    },
    {
      name: "NTT_A_ADDR",
      desc: "Physical base address of the uint32_t polynomial array a[] (mp_NTT/mp_iNTT operand, updated in place)",
      swaccess: "rw",
      hwaccess: "hro",
      fields: [ { bits: "63:0" } ]
    },
    {
      name: "NTT_GM_ADDR",
      desc: "Physical base address of the uint32_t twiddle table (gm[] for forward NTT_CTRL.MODE=0, igm[] for inverse NTT_CTRL.MODE=1 -- caller points this at whichever mp_mkgm/mp_mkigm table the job needs)",
      swaccess: "rw",
      hwaccess: "hro",
      fields: [ { bits: "63:0" } ]
    },
    {
      name: "NTT_LOGN",
      desc: "Degree parameter (log2 n; matches mp_NTT/mp_iNTT's logn argument, n = 1 << logn)",
      swaccess: "rw",
      hwaccess: "hro",
      fields: [ { bits: "4:0" } ]
    },
    {
      name: "NTT_P_VAL",
      desc: "Modulus p for this job (any HAWK-usable prime -- software supplies it directly, matching mp_NTT/mp_iNTT's own p argument, instead of the accelerator hardcoding a fixed prime table)",
      swaccess: "rw",
      hwaccess: "hro",
      fields: [ { bits: "31:0" } ]
    },
    {
      name: "NTT_P0I_VAL",
      desc: "p0i = -1/p mod 2^32 for this job, software-precomputed exactly as mp_NTT/mp_iNTT's own p0i argument (e.g. from the PRIMES[] table)",
      swaccess: "rw",
      hwaccess: "hro",
      fields: [ { bits: "31:0" } ]
    },
    {
      name: "NTT_CTRL",
      desc: "NTT/iNTT accelerator job control and status",
      swaccess: "rw",
      hwaccess: "hrw",
      fields: [
        {
          bits: "0",
          name: "GO",
          desc: "Start the job",
          hwaccess: "hro"
        },
        {
          bits: "1",
          name: "DONE",
          desc: "Asserted if the job is done"
        },
        {
          bits: "4:2",
          name: "MODE",
          desc: "bit0 (reg bit 2): direction, 0 = forward-shaped, 1 = inverse. bit1 (reg bit 3): NTT-family autoadj-reduced-phase variant (mp_NTT_autoadj's post-unfold butterfly stages), only meaningful when bit2=0 and bit0=0. bit2 (reg bit 4): family, 0 = NTT (modular arithmetic), 1 = fixed-point FFT (vect_FFT/vect_iFFT, ng_fxp.c -- shares this engine's address generator and multiplier, see NTT_ACCEL_DESIGN.md's Fixed-point FFT scoping section). Encoding: 000=mp_NTT, 001=mp_iNTT, 010=mp_NTT_autoadj reduced phase, 100=vect_FFT, 101=vect_iFFT.",
          hwaccess: "hro"
        }
      ]
    },
    {
      name: "REJ_X_ADDR",
      desc: "Physical base address of the uint16_t output sample array for the rejection-sampler job (Falcon's Zf(hash_to_point_vartime), common.c)",
      swaccess: "rw",
      hwaccess: "hro",
      fields: [ { bits: "63:0" } ]
    },
    {
      name: "REJ_PARAMS",
      desc: "Rejection-sampler job parameters, packed to keep the register count small: Q (modulus, bits 15:0), THRESH (rejection bound, bits 31:16), N (accepted-sample target, bits 63:32)",
      swaccess: "rw",
      hwaccess: "hro",
      fields: [
        { bits: "15:0", name: "Q", desc: "Modulus for the conditional-subtract reduction (Falcon: 12289)" },
        { bits: "31:16", name: "THRESH", desc: "Reject if the squeezed 16-bit word is >= this (Falcon: 61445 = 5*12289)" },
        { bits: "63:32", name: "N", desc: "Number of accepted samples to produce" }
      ]
    },
    {
      name: "REJ_CTRL",
      desc: "Rejection-sampler job control and status. Requires the accelerator's DATA[] state to already be hardware-resident and shake_flip()-padded (not yet permuted) for the calling shake context before GO is set -- same precondition as SAMP_CTRL.",
      swaccess: "rw",
      hwaccess: "hrw",
      fields: [
        {
          bits: "0",
          name: "GO",
          desc: "Start the rejection-sampler job"
        },
        {
          bits: "1",
          name: "DONE",
          desc: "Asserted if the rejection-sampler job is done"
        }
      ]
    }
  ]
}
